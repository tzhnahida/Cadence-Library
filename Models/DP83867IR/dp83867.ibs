|Texas Instruments Incorporated
| Robust,Low Power 10/100/1000 Ethernet Physical Layer Transceiver
| Marketing part#   Digital Voltage Range   Package-type   #pins
| DP83867RGZ   1.71V-3.46V   QFN   48
| DP83867PAP   1.71V-3.46V   QFN   64
[IBIS Ver]   4.1
[File name]   dp83867.ibs
[File Rev]   1.1
[Date]   2/19/2019
[Source]
| Texas Instruments Incorporated.
| Analog-eLab Design Center, HPA
| 12500 TI Blvd
| Dallas, TX -75243
[Notes]   Revision History:
| Rev 1.1: 2/19/2019
| - Added GPIO_SGMII_IN buffer for TX_D0 and TX_D1 pins with updated CCOMP values.
| Rev 1.0: 1/22/2015
| - Initial version of the model
| - Model generated from simulations in TISPICE
| - Model matched to SPICE simulation
| - C_comp although listed in numerical order of value are
|   obtained from varying PVT conditions. For PVT conditions for
|   each specific value refer the buffer description under
|   respective [Model]. IBIS model user is responsible for using
|   appropriate C_comp to simulate for Signal Integrity.
[Disclaimer]
| This model is designed as an aid for customers of Texas Instruments.
| TI and its licensors and suppliers make no warranties, either expressed
| or implied, with respect to this  model, including the warranties of
| merchantability or fitness for a particular purpose. The model is
| provided solely on an "as is" basis. The entire risk as to its quality
| and performance is with the customer.
[Copyright]
(C) Copyright 2019 Texas Instruments Incorporated.All rights reserved.
|   DP83867RGZ
[Component]   DP83867RGZ
[Manufacturer]   TI
[Package]   |48 QFN - RGZ package
|   typ   min   max
R_pkg   0.20591   0.17549   0.25029
L_pkg   2.22578nH   1.86813nH   2.74598nH
C_pkg   0.20388pF   0.17973pF   0.23221pF
[Pin]  signal_name   model_name   R_pin   L_pin   C_pin
1   TD_P_A   NC   0.25497   2.80728nH  0.23843pF
2   TD_M_A   NC   0.22942   2.50500nH  0.22986pF
3   VDDA2P5   POWER   0.10622   1.77680nH  0.27526pF
4   TD_P_B   NC   0.19896   2.14930nH  0.20075pF
5   TD_M_B   NC   0.19060   2.05213nH  0.19481pF
6   VDDA1P1   POWER   0.18909   2.03461nH  0.18879pF
7   TD_P_C   NC   0.18991   2.04401nH  0.19428pF
8   TD_M_C   NC   0.19709   2.12753nH  0.19915pF
9   VDDA2P5   POWER   0.10484   1.74000nH  0.27195pF
10   TD_P_D   NC   0.22594   2.46362nH  0.22536pF
11   TD_M_D   NC   0.24833   2.72572nH  0.24965pF
12   RBIAS   NC   0.27089   2.99328nH  0.23752pF
13   VDDA1P8   POWER   0.12157   2.39556nH  0.23126pF
14   X_O   NC   0.22841   2.49262nH  0.21841pF
15   X_I   NC   0.20764   2.24892nH  0.20972pF
16   MDC   GPI   0.19484   2.09909nH  0.20111pF
17   MDIO   IO   0.18410   1.97323nH  0.18410pF
18   CLK_OUT   GPIO   0.18090   1.93530nH  0.17973pF
19   VDDIO   POWER   0.09064   1.45091nH  0.24480pF
20   JTAG_CLK   GPI   0.18260   1.95433nH  0.19060pF
21   JTAG_TDO   GPIO   0.19167   2.05889nH  0.19363pF
22   JTAG_TMS   GPI   0.20728   2.24012nH  0.20728pF
23   JTAG_TDI   GPI   0.22797   2.48162nH  0.23178pF
24   VDD1P1   POWER   0.12378   2.44090nH  0.24958pF
25   TX_D3   GPI   0.24533   2.68817nH  0.22504pF
26   TX_D2   GPI   0.21872   2.37322nH  0.21900pF
27   TX_D1   GPIO_SGMII_IN   0.19854   2.13682nH  0.19925pF
28   TX_D0   GPIO_SGMII_IN   0.18382   1.96499nH  0.18073pF
29   GTX_CLK   GPI   0.19681   2.11633nH  0.19692pF
30   VDDIO   POWER   0.09208   1.48937nH  0.24534pF
31   VDD1P1   POWER   0.17647   1.87951nH  0.18737pF
32   RX_CLK   GPIO   0.17549   1.86813nH  0.18492pF
33   RX_D0   GPIO   0.18164   1.93979nH  0.18654pF
34   RX_D1   GPIO   0.19507   2.09642nH  0.20245pF
35   RX_D2   GPIO   0.21025   2.27432nH  0.21411pF
36   RX_D3   GPIO   0.23556   2.57398nH  0.20419pF
37   TX_CTRL   GPIO   0.25029   2.74598nH  0.22397pF
38   RX_CTRL   GPIO   0.22824   2.48482nH  0.23221pF
39   GPIO   GPIO   0.20750   2.24263nH  0.20735pF
40   GPIO   GPIO   0.19182   2.06060nH  0.19218pF
41   VDDIO   POWER   0.09247   1.49087nH  0.23995pF
42   VDD1P1   POWER   0.18079   1.93381nH  0.18623pF
43   RESET_N   GPI   0.18418   1.97421nH  0.18760pF
44   INT/PWDN   IO   0.19501   2.10103nH  0.20172pF
45   LED_2   IO   0.20838   2.25739nH  0.21142pF
46   LED_1   IO   0.22932   2.50242nH  0.22034pF
47   LED_0   IO   0.24840   2.72652nH  0.22278pF
48   VDDA1P8   POWER   0.12157   2.39556nH  0.22679pF
|   DP83867PAP
[Component]   DP83867PAP
[Manufacturer]   TI
[Package]   |64 QFN - PAP package
|   typ   min   max
R_pkg   0.18021   0.16388   0.21710
L_pkg   4.16219nH   3.85228nH   4.80080nH
C_pkg   0.63166pF   0.59196pF   0.67524pF
[Pin]  signal_name   model_name   R_pin   L_pin   C_pin
1   RESERVED   NC   0.21127   4.79510nH  0.63933pF
2   TD_P_A   NC   0.20172   4.55351nH  0.69228pF
3   TD_M_A   NC   0.19174   4.36197nH  0.66422pF
4   VDDA2P5   POWER   0.09930   3.81004nH  0.70773pF
5   TD_P_B   NC   0.17989   4.12012nH  0.63563pF
6   TD_M_B   NC   0.17597   4.04021nH  0.63310pF
7   RESERVED   NC   0.17463   4.01485nH  0.62284pF
8   VDD1P1   POWER   0.17379   3.98991nH  0.60614pF
9   RESERVED   NC   0.17520   4.01306nH  0.61337pF
10   TD_P_C   NC   0.17695   4.05389nH  0.62935pF
11   TD_M_C   NC   0.18119   4.12643nH  0.63394pF
12   VDDA2P5   POWER   0.09999   3.81635nH  0.70523pF
13   TD_P_D   NC   0.19311   4.35986nH  0.65895pF
14   TD_M_D   NC   0.20281   4.54608nH  0.68911pF
15   RBIAS   NC   0.21131   4.71605nH  0.69200pF
16   RESERVED   NC   0.11359   4.39142nH  0.68082pF
17   VDDA1P8   POWER   0.11132   4.33552nH  0.64196pF
18   X_O   NC   0.20308   4.58560nH  0.67362pF
19   X_I   NC   0.19177   4.37225nH  0.67090pF
20   MDC   GPI   0.18522   4.23695nH  0.65762pF
21   MDIO   IO   0.17774   4.09438nH  0.62484pF
22   CLK_OUT   GPIO   0.17420   4.01967nH  0.61220pF
23   VDDIO   POWER   0.09400   3.62923nH  0.68695pF
24   JTAG_TRSTN   GPI   0.17070   3.94695nH  0.61568pF
25   JTAG_CLK   GPI   0.16851   3.91264nH  0.61034pF
26   JTAG_TDO   GPIO   0.16741   3.90780nH  0.60977pF
27   JTAG_TMS   GPI   0.16833   3.92713nH  0.61592pF
28   JTAG_TDI   GPI   0.17139   3.99396nH  0.63586pF
29   VDD1P1   POWER   0.09396   3.66111nH  0.70464pF
30   TX_CLK   GPIO   0.18002   4.18601nH  0.64956pF
31   TX_D7   GPI   0.18902   4.36224nH  0.66233pF
32   TX_D6   GPI   0.20079   4.63951nH  0.59258pF
33   TX_D5   GPI   0.19998   4.63094nH  0.59196pF
34   TX_D4   GPI   0.18751   4.34117nH  0.67185pF
35   TX_D3   GPI   0.18007   4.18836nH  0.65871pF
36   TX_D2   GPI   0.17238   4.03415nH  0.63035pF
37   TX_D1   GPIO_SGMII_IN   0.16703   3.92426nH  0.61700pF
38   TX_D0   GPIO_SGMII_IN   0.16396   3.85570nH  0.59788pF
39   TX_ER   GPI   0.16990   3.94577nH  0.61191pF
40   GTX_CLK   GPI   0.16565   3.86516nH  0.59990pF
41   VDDIO   POWER   0.08848   3.45628nH  0.65128pF
42   VDD1P1   POWER   0.16310   3.83568nH  0.61577pF
43   RX_CLK   GPIO   0.16388   3.85228nH  0.61944pF
44   RX_D0   GPIO   0.16691   3.91759nH  0.61885pF
45   RX_D1   GPIO   0.17222   4.02493nH  0.64019pF
46   RX_D2   GPIO   0.17764   4.14141nH  0.65413pF
47   RX_D3   GPIO   0.18723   4.32630nH  0.66138pF
48   RX_D4/GPIO   GPIO   0.19965   4.61270nH  0.59331pF
49   RX_D5/GPIO   GPIO   0.20396   4.68156nH  0.61904pF
50   RX_D6/GPIO   GPIO   0.19170   4.39580nH  0.66709pF
51   RXD_7/GPIO   GPIO   0.18219   4.21085nH  0.64966pF
52   TX_EN/TX_CTRL   GPIO   0.17510   4.06684nH  0.64236pF
53   RX_DV/RX_CTRL   GPIO   0.17146   3.98510nH  0.63279pF
54   RX_ER/GPIO   GPIO   0.16836   3.91701nH  0.61551pF
55   COL/GPIO   GPIO   0.16742   3.89752nH  0.60892pF
56   CS/GPIO   GPIO   0.16847   3.90150nH  0.60261pF
57   VDDIO   POWER   0.09231   3.56242nH  0.66211pF
58   VDD1P1   POWER   0.17516   4.02025nH  0.62215pF
59   RESET_N   GPI   0.18139   4.12399nH  0.63309pF
60   INT/PWDN   IO   0.18946   4.27090nH  0.65928pF
61   LED_2   IO   0.19639   4.40558nH  0.67224pF
62   LED_1   IO   0.20775   4.61784nH  0.67524pF
63   LED_0   IO   0.21710   4.80080nH  0.67168pF
64   VDDA1P8   POWER   0.11131   4.33117nH  0.62959pF
|   Model Selectors
[Model Selector] GPI
gpi_1p8   1.8V  digital Input
gpi_2p5   2.5V  digital Input
gpi_3p3   3.3V  digital Input
[Model Selector] GPIO_SGMII_IN
gpio_sgmii_in_1p8   1.8V  digital Input
gpio_sgmii_in_2p5   2.5V  digital Input
gpio_sgmii_in_3p3   3.3V  digital Input
[Model Selector] GPIO
gpio_1p8   1.8V  digital Output
gpio_2p5   2.5V  digital Output
gpio_3p3   3.3V  digital Output
[Model Selector] IO
io_1p8   1.8V  digital I/O
io_2p5   2.5V  digital I/O
io_3p3   3.3V  digital I/O
| Models and submodels in the file (12): gpio_sgmii_in_1p8 (Input), gpio_sgmii_in_2p5 (Input), gpio_sgmii_in_3p3 (Input), gpi_1p8 (Input), gpi_2p5 (Input), gpi_3p3 (Input), gpio_1p8 (Output), gpio_2p5 (Output), gpio_3p3 (Output), io_1p8 (I/O), io_2p5 (I/O), io_3p3 (I/O)
